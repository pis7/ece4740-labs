// Generated for: spectre
// Generated on: Mar 25 20:53:32 2024
// Design library name: ece4740
// Design cell name: lab2_nora_sim
// Design view name: schematic
simulator lang=spectre
global 0 vdd!
include "/opt/cadence-designkits/gpdk090_v3.9/libs.oa22/gpdk090/../../models/spectre/gpdk090.scs" section=NN

// Library name: ece4740
// Cell name: lab2_nora
// View name: av_extracted
// View type: maskLayout
subckt lab2_nora A B Y phi phi_bar
    c1 (\8\:net2 \1\:phi_bar) capacitor c=3.70778e-18
    c2 (\1\:phi \4\:gnd!) capacitor c=1.87553e-17
    c3 (vdd! \3\:phi) capacitor c=5.79329e-18
    c4 (phi A) capacitor c=1.54488e-17
    c5 (vdd! \9\:phi) capacitor c=5.73243e-18
    c6 (vdd! \3\:phi_bar) capacitor c=7.02055e-18
    c7 (vdd! \12\:net1) capacitor c=3.68772e-18
    c8 (vdd! \12\:net2) capacitor c=3.69581e-18
    c9 (vdd! \15\:phi) capacitor c=5.73544e-18
    c10 (vdd! \1\:phi) capacitor c=2.79103e-18
    c11 (\4\:net2 \4\:gnd!) capacitor c=1.02851e-18
    c12 (\11\:net1 \1\:phi_bar) capacitor c=8.02589e-19
    c13 (\5\:net1 vdd!) capacitor c=1.02872e-17
    c14 (\9\:net2 \4\:net3) capacitor c=9.49057e-19
    c15 (\1\:phi \1\:vdd!) capacitor c=4.58014e-17
    c16 (\11\:net1 vdd!) capacitor c=1.25287e-17
    c17 (\5\:net3 vdd!) capacitor c=4.43809e-18
    c18 (A \3\:phi) capacitor c=1.5759e-18
    c19 (\11\:net3 vdd!) capacitor c=6.11184e-18
    c20 (\1\:B \4\:net2) capacitor c=2.70868e-17
    c21 (\1\:A \4\:gnd!) capacitor c=3.80727e-18
    c22 (A \5\:phi) capacitor c=4.8357e-18
    c23 (B \9\:phi) capacitor c=2.13771e-18
    c24 (\4\:net2 \9\:phi) capacitor c=1.4174e-18
    c25 (A \1\:phi) capacitor c=7.11678e-18
    c26 (\12\:phi \10\:net1) capacitor c=1.92446e-17
    c27 (\1\:A \1\:vdd!) capacitor c=2.61021e-17
    c28 (B \11\:phi) capacitor c=4.8357e-18
    c29 (\4\:vdd! \9\:phi) capacitor c=2.99622e-18
    c30 (\5\:net3 \9\:net1) capacitor c=7.65384e-19
    c31 (\2\:phi A) capacitor c=7.98262e-18
    c32 (\4\:net2 \1\:vdd!) capacitor c=6.6244e-18
    c33 (\12\:phi \4\:net3) capacitor c=1.28084e-17
    c34 (\12\:phi \1\:phi_bar) capacitor c=2.03658e-18
    c35 (\4\:net2 \1\:phi_bar) capacitor c=2.54339e-18
    c36 (Y \15\:phi) capacitor c=3.54558e-18
    c37 (A \1\:vdd!) capacitor c=2.8374e-18
    c38 (phi \1\:A) capacitor c=2.16606e-18
    c39 (\1\:B \4\:gnd!) capacitor c=3.65155e-18
    c40 (\5\:net1 B) capacitor c=1.6276e-18
    c41 (\6\:phi B) capacitor c=7.79416e-18
    c42 (\11\:net1 B) capacitor c=1.15699e-18
    c43 (\1\:B \1\:vdd!) capacitor c=2.62622e-17
    c44 (Y \16\:phi) capacitor c=3.64622e-19
    c45 (\4\:vdd! \3\:phi_bar) capacitor c=1.21614e-17
    c46 (B \1\:vdd!) capacitor c=4.59757e-19
    c47 (\1\:phi_bar \4\:gnd!) capacitor c=1.82688e-17
    c48 (phi_bar \9\:net1) capacitor c=7.29715e-19
    c49 (\6\:phi \5\:net1) capacitor c=6.39781e-17
    c50 (\1\:phi_bar \1\:vdd!) capacitor c=2.11746e-17
    c51 (phi \4\:gnd!) capacitor c=7.22885e-18
    c52 (\6\:phi phi_bar) capacitor c=6.91378e-18
    c53 (phi \1\:vdd!) capacitor c=1.53649e-17
    c54 (\10\:net1 \3\:phi_bar) capacitor c=6.28801e-18
    c55 (\8\:net2 phi_bar) capacitor c=3.92498e-18
    c56 (Y \14\:phi) capacitor c=2.92129e-19
    c57 (phi_bar \11\:net1) capacitor c=1.36446e-17
    c58 (\12\:phi phi_bar) capacitor c=8.07495e-18
    c59 (\4\:vdd! \12\:net1) capacitor c=1.9326e-18
    c60 (\9\:phi \3\:phi_bar) capacitor c=1.63093e-18
    c61 (\9\:net1 \1\:vdd!) capacitor c=1.7376e-17
    c62 (phi_bar \4\:gnd!) capacitor c=3.50635e-18
    c63 (phi_bar \1\:vdd!) capacitor c=3.20525e-18
    c64 (\8\:net2 \6\:phi) capacitor c=2.21786e-17
    c65 (\10\:net1 \1\:phi_bar) capacitor c=1.30259e-17
    c66 (\11\:net3 \14\:phi) capacitor c=8.87613e-18
    c67 (\3\:phi_bar \12\:net1) capacitor c=1.23627e-17
    c68 (\12\:phi Y) capacitor c=3.20035e-18
    c69 (\4\:net1 B) capacitor c=2.06833e-18
    c70 (\4\:net3 \4\:gnd!) capacitor c=6.70493e-18
    c71 (\11\:net3 Y) capacitor c=7.46543e-18
    c72 (\6\:phi \11\:net1) capacitor c=7.32294e-17
    c73 (Y \4\:gnd!) capacitor c=4.83919e-18
    c74 (\4\:net3 \1\:phi_bar) capacitor c=1.4824e-18
    c75 (Y \1\:vdd!) capacitor c=1.92189e-17
    c76 (\14\:phi \4\:gnd!) capacitor c=1.37798e-17
    c77 (\12\:net1 \12\:net2) capacitor c=1.27697e-17
    c78 (\10\:net1 \4\:net3) capacitor c=3.52901e-17
    c79 (\10\:net1 \1\:vdd!) capacitor c=5.26119e-18
    c80 (\11\:net1 \8\:net2) capacitor c=2.80421e-18
    c81 (\14\:phi \1\:vdd!) capacitor c=3.4753e-17
    c82 (phi \4\:net1) capacitor c=1.08727e-18
    c83 (\4\:net3 \1\:vdd!) capacitor c=2.54877e-18
    c84 (\4\:net3 \9\:net1) capacitor c=3.39867e-18
    c85 (\2\:phi \4\:gnd!) capacitor c=8.18742e-18
    c86 (\1\:A \3\:phi) capacitor c=1.84342e-17
    c87 (\11\:net3 \13\:phi) capacitor c=9.54361e-18
    c88 (\11\:net1 \5\:net3) capacitor c=7.83112e-18
    c89 (\6\:phi \4\:net1) capacitor c=9.23881e-18
    c90 (\2\:phi \1\:vdd!) capacitor c=2.02152e-17
    c91 (\5\:phi \2\:A) capacitor c=4.03368e-17
    c92 (\8\:net2 \12\:phi) capacitor c=5.99081e-18
    c93 (\1\:B \9\:phi) capacitor c=1.78729e-17
    c94 (\4\:net2 phi_bar) capacitor c=5.10741e-18
    c95 (\2\:A \11\:phi) capacitor c=8.586e-19
    c96 (\5\:net1 \1\:vdd!) capacitor c=2.04558e-17
    c97 (\6\:phi \4\:gnd!) capacitor c=1.12125e-17
    c98 (phi_bar \10\:net1) capacitor c=2.01882e-17
    c99 (\13\:phi \4\:gnd!) capacitor c=4.51411e-18
    c100 (phi_bar \4\:net3) capacitor c=3.44427e-18
    c101 (\11\:phi \2\:B) capacitor c=4.11447e-17
    c102 (\6\:phi \1\:vdd!) capacitor c=9.31648e-18
    c103 (\3\:phi_bar \9\:net1) capacitor c=1.5751e-18
    c104 (\8\:net2 \4\:gnd!) capacitor c=4.36013e-17
    c105 (\5\:net1 \3\:phi) capacitor c=1.68869e-17
    c106 (\12\:phi \5\:net3) capacitor c=4.64361e-17
    c107 (\5\:net1 \9\:phi) capacitor c=1.68226e-18
    c108 (\5\:phi \1\:A) capacitor c=9.9373e-18
    c109 (\9\:net2 \12\:phi) capacitor c=2.55862e-17
    c110 (\13\:phi \1\:vdd!) capacitor c=8.92589e-18
    c111 (\11\:net1 \1\:vdd!) capacitor c=3.43823e-17
    c112 (\11\:net1 \9\:phi) capacitor c=4.32532e-18
    c113 (\13\:phi Y) capacitor c=1.27951e-18
    c114 (\12\:net2 \14\:phi) capacitor c=8.57324e-19
    c115 (\11\:net1 \3\:phi_bar) capacitor c=1.55114e-18
    c116 (\5\:net3 \1\:vdd!) capacitor c=3.61118e-18
    c117 (\9\:net2 \4\:gnd!) capacitor c=3.46339e-17
    c118 (\16\:phi \12\:net3) capacitor c=4.15615e-17
    c119 (\12\:phi \11\:net3) capacitor c=3.2424e-17
    c120 (\3\:phi \1\:vdd!) capacitor c=3.93842e-17
    c121 (\11\:phi \1\:B) capacitor c=9.9373e-18
    c122 (\5\:net3 \3\:phi_bar) capacitor c=2.53435e-18
    c123 (\6\:phi \4\:net2) capacitor c=8.46999e-18
    c124 (\12\:phi \4\:gnd!) capacitor c=7.78179e-18
    c125 (\12\:phi \3\:phi_bar) capacitor c=1.36741e-18
    c126 (\9\:phi \1\:vdd!) capacitor c=3.59872e-17
    c127 (\5\:net3 \12\:net1) capacitor c=8.4561e-18
    c128 (\12\:phi \1\:vdd!) capacitor c=7.74025e-18
    c129 (\5\:net3 \12\:net2) capacitor c=1.25116e-17
    c130 (\3\:phi_bar \1\:vdd!) capacitor c=2.1081e-17
    c131 (\6\:phi \4\:vdd!) capacitor c=2.29112e-18
    c132 (\1\:phi \1\:A) capacitor c=9.23467e-18
    c133 (\2\:phi_bar \9\:net1) capacitor c=7.4823e-18
    c134 (\11\:net3 \1\:vdd!) capacitor c=1.33331e-17
    c135 (\12\:net1 \1\:vdd!) capacitor c=1.5296e-17
    c136 (\2\:phi_bar \14\:phi) capacitor c=3.50207e-19
    c137 (\4\:net1 \1\:phi) capacitor c=1.21478e-18
    c138 (\11\:net1 \4\:net2) capacitor c=2.079e-17
    c139 (\12\:net2 \1\:vdd!) capacitor c=1.82691e-17
    c140 (\11\:net3 \15\:phi) capacitor c=9.24492e-18
    c141 (\8\:net2 \11\:phi) capacitor c=6.82888e-18
    c142 (\15\:phi \1\:vdd!) capacitor c=3.87405e-17
    c143 (\10\:net1 \2\:phi_bar) capacitor c=4.00176e-18
    c144 (\1\:A \4\:net1) capacitor c=2.53863e-17
    c145 (\8\:net2 \2\:B) capacitor c=1.63093e-17
    c146 (\5\:phi \4\:gnd!) capacitor c=2.63681e-17
    c147 (\11\:net1 \4\:vdd!) capacitor c=2.52018e-17
    c148 (\4\:net3 \2\:phi_bar) capacitor c=6.11291e-18
    c149 (\4\:net1 \4\:gnd!) capacitor c=1.03317e-18
    c150 (\8\:net2 \2\:phi_bar) capacitor c=2.3754e-18
    c151 (\2\:A \4\:gnd!) capacitor c=1.62875e-17
    c152 (\5\:net3 I13\|net2) capacitor c=8.10807e-19
    c153 (\1\:phi_bar \9\:net1) capacitor c=1.07142e-17
    c154 (\5\:net3 \4\:vdd!) capacitor c=7.88268e-19
    c155 (\11\:phi \4\:gnd!) capacitor c=1.88851e-17
    c156 (\4\:net1 \1\:vdd!) capacitor c=5.24523e-18
    c157 (\2\:phi \1\:A) capacitor c=3.62248e-18
    c158 (\9\:net2 \2\:phi_bar) capacitor c=3.97509e-18
    c159 (\4\:net2 \10\:net1) capacitor c=1.33493e-18
    c160 (\12\:phi \2\:phi_bar) capacitor c=6.54949e-19
    c161 (\2\:B \4\:gnd!) capacitor c=1.74642e-17
    c162 (\4\:net1 \1\:B) capacitor c=4.01964e-19
    c163 (\9\:net2 \16\:phi) capacitor c=3.36667e-18
    c164 (\6\:phi \1\:A) capacitor c=8.81479e-18
    c165 (\2\:phi_bar \4\:gnd!) capacitor c=2.85296e-17
    c166 (\10\:net1 \5\:net3) capacitor c=1.24282e-17
    c167 (\16\:phi \4\:gnd!) capacitor c=2.47865e-17
    c168 (\6\:phi \1\:B) capacitor c=9.54476e-18
    c169 (\12\:phi \4\:vdd!) capacitor c=1.77809e-18
    c170 (\8\:net2 \1\:B) capacitor c=6.6336e-19
    c171 (\12\:net3 \4\:gnd!) capacitor c=2.47959e-17
    c172 (\10\:net1 \4\:vdd!) capacitor c=1.82937e-18
    c173 (\11\:net1 \1\:B) capacitor c=4.44903e-18
    c174 (\9\:net2 \10\:net1) capacitor c=2.10424e-18
    c175 (\12\:phi \2\:gnd!) capacitor c=3.88756e-18
    c176 (\2\:net2 \9\:phi) capacitor c=1.14747e-17
    c177 (\5\:Y vdd!) capacitor c=8.86082e-18
    c178 (\6\:vdd! \12\:net2) capacitor c=2.03503e-18
    c179 (\2\:net1 \5\:phi) capacitor c=4.38105e-18
    c180 (\12\:phi \10\:net2) capacitor c=1.74538e-17
    c181 (\2\:Y \12\:net3) capacitor c=1.20635e-17
    c182 (\1\:B \2\:net2) capacitor c=2.51377e-18
    c183 (\13\:phi \10\:net2) capacitor c=2.37218e-17
    c184 (\2\:gnd! \13\:phi) capacitor c=5.48476e-18
    c185 (\10\:net2 \2\:phi_bar) capacitor c=8.18227e-19
    c186 (\16\:vdd! \7\:net1) capacitor c=1.52939e-17
    c187 (\10\:net1 \10\:net2) capacitor c=1.09516e-18
    c188 (\9\:gnd! \2\:net3) capacitor c=9.94539e-18
    c189 (\7\:net1 \1\:vdd!) capacitor c=1.1478e-17
    c190 (\1\:A \7\:phi) capacitor c=4.47384e-18
    c191 (\10\:net2 \1\:phi_bar) capacitor c=5.73433e-19
    c192 (\16\:vdd! \3\:phi) capacitor c=1.30812e-17
    c193 (\2\:A \7\:phi) capacitor c=3.62635e-19
    c194 (\5\:net3 \2\:I13\|net2) capacitor c=3.70448e-17
    c195 (\11\:net3 \10\:net2) capacitor c=2.7967e-18
    c196 (\9\:gnd! \2\:B) capacitor c=9.34152e-19
    c197 (\15\:gnd! phi) capacitor c=5.48476e-18
    c198 (\2\:gnd! \2\:Y) capacitor c=8.61083e-18
    c199 (\2\:I13\|net2 \10\:net2) capacitor c=1.14576e-17
    c200 (\12\:gnd! \2\:A) capacitor c=2.59578e-18
    c201 (\9\:net2 \9\:gnd!) capacitor c=1.28417e-17
    c202 (\4\:net3 \10\:net2) capacitor c=4.79101e-17
    c203 (\2\:gnd! \2\:phi_bar) capacitor c=7.46754e-19
    c204 (\6\:phi \2\:net1) capacitor c=3.18102e-18
    c205 (A \16\:vdd!) capacitor c=5.38514e-18
    c206 (\4\:vdd! \5\:I13\|net2) capacitor c=3.40916e-17
    c207 (\11\:net3 \5\:Y) capacitor c=6.46197e-18
    c208 (\9\:net2 \2\:net3) capacitor c=2.97769e-17
    c209 (\2\:gnd! \12\:net3) capacitor c=3.55179e-18
    c210 (\5\:Y \1\:vdd!) capacitor c=3.18798e-17
    c211 (\6\:vdd! \5\:Y) capacitor c=1.15725e-17
    c212 (Y \9\:net3) capacitor c=3.09123e-17
    c213 (\10\:net2 \9\:net1) capacitor c=1.00667e-17
    c214 (\12\:gnd! \2\:B) capacitor c=3.17516e-18
    c215 (\6\:phi \12\:gnd!) capacitor c=5.75569e-18
    c216 (\11\:net3 \6\:vdd!) capacitor c=1.49814e-17
    c217 (\2\:I13\|net2 \12\:net1) capacitor c=2.061e-18
    c218 (\10\:vdd! \7\:phi) capacitor c=2.57212e-18
    c219 (\10\:net2 \4\:gnd!) capacitor c=4.7054e-18
    c220 (\15\:gnd! \2\:A) capacitor c=3.74745e-18
    c221 (\7\:net1 \3\:phi) capacitor c=8.85315e-18
    c222 (\5\:I13\|net2 \5\:net3) capacitor c=2.72078e-17
    c223 (\2\:gnd! \14\:phi) capacitor c=6.35832e-18
    c224 (\5\:net1 \7\:phi) capacitor c=1.5531e-17
    c225 (\5\:I13\|net2 \1\:phi_bar) capacitor c=7.55421e-19
    c226 (\2\:net1 \12\:gnd!) capacitor c=6.49584e-18
    c227 (\2\:net1 \2\:B) capacitor c=5.02914e-19
    c228 (\7\:phi \1\:B) capacitor c=1.17575e-17
    c229 (\2\:phi \15\:gnd!) capacitor c=5.81594e-18
    c230 (\5\:I13\|net2 \12\:net1) capacitor c=1.98418e-17
    c231 (\9\:gnd! \1\:phi_bar) capacitor c=3.63031e-18
    c232 (\12\:phi \9\:net3) capacitor c=5.89941e-18
    c233 (\6\:phi \7\:net1) capacitor c=3.18556e-18
    c234 (\2\:net2 \3\:phi_bar) capacitor c=1.81297e-18
    c235 (\16\:phi \9\:net3) capacitor c=1.42197e-17
    c236 (\9\:net3 \15\:phi) capacitor c=1.83035e-17
    c237 (\9\:net2 \2\:gnd!) capacitor c=1.72484e-17
    c238 (\2\:net1 \4\:gnd!) capacitor c=1.3625e-17
    c239 (\11\:net3 \2\:gnd!) capacitor c=1.18628e-18
    c240 (\2\:net1 \2\:A) capacitor c=8.61314e-18
    c241 (\10\:vdd! \9\:phi) capacitor c=1.26193e-17
    c242 (\10\:net2 \1\:vdd!) capacitor c=3.20457e-17
    c243 (\7\:phi \4\:gnd!) capacitor c=1.60405e-17
    c244 (\12\:gnd! \7\:phi) capacitor c=1.16001e-17
    c245 (\11\:net1 \10\:vdd!) capacitor c=1.98264e-18
    c246 (\2\:Y \16\:phi) capacitor c=4.47931e-18
    c247 (\2\:Y \9\:net3) capacitor c=1.05569e-18
    c248 (\6\:vdd! \15\:phi) capacitor c=1.31783e-17
    c249 (\2\:net3 \2\:phi_bar) capacitor c=8.83486e-18
    c250 (\2\:net2 \1\:vdd!) capacitor c=1.12804e-17
    c251 (\2\:Y \4\:gnd!) capacitor c=3.20264e-17
    c252 (\15\:gnd! \1\:phi) capacitor c=6.1153e-18
    c253 (\9\:gnd! \10\:net1) capacitor c=2.80171e-18
    c254 (\5\:Y \15\:phi) capacitor c=1.21551e-17
    c255 (\16\:vdd! \1\:phi) capacitor c=3.17945e-18
    c256 (\10\:net2 \14\:phi) capacitor c=1.04287e-17
    c257 (\2\:I13\|net2 \6\:vdd!) capacitor c=1.25025e-17
    c258 (\7\:phi \1\:vdd!) capacitor c=4.41801e-17
    c259 (\2\:I13\|net2 \1\:vdd!) capacitor c=1.70182e-17
    c260 (\2\:I13\|net2 \11\:net3) capacitor c=1.70016e-18
    c261 (\8\:net2 \9\:gnd!) capacitor c=4.63605e-18
    c262 (B \7\:phi) capacitor c=2.20157e-17
    c263 (\2\:net1 \1\:A) capacitor c=8.3372e-19
    c264 (\7\:net1 \10\:vdd!) capacitor c=4.57155e-18
    c265 (\9\:net3 \5\:Y) capacitor c=3.55461e-18
    c266 (\5\:net3 \10\:net2) capacitor c=1.4212e-17
    c267 (\2\:net1 \8\:net2) capacitor c=3.28608e-18
    c268 (\9\:gnd! \2\:phi_bar) capacitor c=9.48339e-18
    c269 (\2\:net3 \4\:gnd!) capacitor c=5.04514e-18
    c270 (\11\:net1 \2\:net2) capacitor c=3.07545e-17
    c271 (\9\:net3 \4\:gnd!) capacitor c=5.52407e-18
    c272 (\10\:net1 \5\:I13\|net2) capacitor c=2.04e-17
    c273 (\2\:gnd! \16\:phi) capacitor c=1.03552e-17
    c274 (B \10\:vdd!) capacitor c=2.97639e-18
    c275 (\12\:gnd! \11\:phi) capacitor c=9.42688e-18
    c276 (\10\:net2 \9\:net3) capacitor c=3.41293e-18
    c277 (\12\:phi \9\:gnd!) capacitor c=2.18023e-18
    c278 (\2\:phi \16\:vdd!) capacitor c=4.96845e-18
    c279 (\7\:phi \4\:net2) capacitor c=2.52311e-18
    c280 (\15\:gnd! \5\:phi) capacitor c=1.12178e-17
    c281 (\4\:net1 \7\:phi) capacitor c=2.11306e-17
    c282 (\7\:net1 \9\:phi) capacitor c=1.75115e-18
    c283 (\1\:A \7\:net1) capacitor c=3.13557e-18
    c284 (\6\:vdd! \14\:phi) capacitor c=1.3953e-18
    c285 (\10\:vdd! \2\:net2) capacitor c=1.52939e-17
    c286 (\5\:net1 \10\:vdd!) capacitor c=6.65466e-18
    c287 (\2\:I13\|net2 \12\:net2) capacitor c=2.20263e-17
    c288 (\12\:gnd! \8\:net2) capacitor c=1.5364e-17
    c289 (\2\:I13\|net2 \3\:phi_bar) capacitor c=6.20361e-19
    c290 (\15\:gnd! \2\:net1) capacitor c=8.61083e-18
    c291 (\5\:I13\|net2 \1\:vdd!) capacitor c=1.67183e-17
    c292 (\11\:net1 \5\:I13\|net2) capacitor c=1.08802e-18
    c293 (\7\:net1 vdd!) capacitor c=8.86033e-18
    c294 (\13\:phi \9\:net3) capacitor c=2.59917e-17
    c295 (\2\:net2 vdd!) capacitor c=8.86082e-18
    c296 (\2\:net3 \10\:net2) capacitor c=5.79389e-18
    c297 (\5\:I13\|net2 \12\:net2) capacitor c=2.83515e-18
    c298 (\5\:I13\|net2 \3\:phi_bar) capacitor c=1.04996e-17
    c299 (\2\:net2 \4\:vdd!) capacitor c=1.0033e-17
    c300 (\9\:net3 \1\:vdd!) capacitor c=3.16842e-17
    c301 (\10\:vdd! \3\:phi) capacitor c=2.6763e-18
    c302 (\9\:net3 \14\:phi) capacitor c=1.72436e-17
    c303 (\2\:net1 \11\:phi) capacitor c=2.29994e-18
    c304 (\2\:I13\|net2 vdd!) capacitor c=3.32297e-17
    c305 (vdd! \5\:I13\|net2) capacitor c=3.01566e-17
    c306 (vdd! \7\:phi) capacitor c=1.00538e-18
    c307 (\6\:phi \10\:vdd!) capacitor c=1.06723e-18
    c308 (vdd! \14\:phi) capacitor c=1.09019e-18
    c309 (\5\:net3 \2\:net2) capacitor c=3.32874e-19
    c310 (\9\:net2 net3) capacitor c=3.72212e-19
    c311 (\11\:net3 \12\:net2) capacitor c=5.09078e-19
    c312 (\9\:net2 \12\:net3) capacitor c=6.84098e-19
    c313 (\12\:phi \11\:net1) capacitor c=4.75005e-19
    c314 (\12\:phi \9\:net1) capacitor c=5.459e-19
    c315 (\2\:net1 \7\:phi) capacitor c=8.00808e-19
    c316 (\10\:net2 \16\:phi) capacitor c=6.35168e-19
    c317 (\12\:net2 \15\:phi) capacitor c=7.65176e-19
    c318 (\4\:net3 \14\:phi) capacitor c=5.42255e-19
    c319 (\5\:net3 \14\:phi) capacitor c=7.10716e-19
    c320 (\9\:net2 \1\:phi_bar) capacitor c=2.8927e-19
    c321 (\9\:net2 \9\:net1) capacitor c=4.93531e-19
    c322 (\7\:net1 \2\:net2) capacitor c=7.83497e-19
    c323 (A 0) capacitor c=9.16158e-19
    c324 (B 0) capacitor c=1.30688e-18
    c325 (phi 0) capacitor c=3.2126e-18
    c326 (phi_bar 0) capacitor c=4.44484e-18
    c327 (\3\:phi_bar 0) capacitor c=1.71645e-19
    c328 (\12\:net2 0) capacitor c=9.38648e-20
    c329 (\15\:phi 0) capacitor c=2.85994e-18
    c330 (\5\:phi 0) capacitor c=8.8775e-18
    c331 (\2\:A 0) capacitor c=7.86229e-18
    c332 (\11\:phi 0) capacitor c=8.05943e-18
    c333 (\2\:B 0) capacitor c=8.16773e-18
    c334 (\2\:phi_bar 0) capacitor c=4.86342e-18
    c335 (\16\:phi 0) capacitor c=7.61218e-18
    c336 (\12\:net3 0) capacitor c=8.04745e-18
    c337 (\1\:phi 0) capacitor c=1.34841e-18
    c338 (\1\:A 0) capacitor c=2.5419e-18
    c339 (\7\:phi 0) capacitor c=4.20504e-18
    c340 (\1\:B 0) capacitor c=5.70372e-18
    c341 (\1\:phi_bar 0) capacitor c=4.82777e-18
    c342 (\9\:net1 0) capacitor c=1.04024e-18
    c343 (\10\:net2 0) capacitor c=3.68039e-18
    c344 (\14\:phi 0) capacitor c=1.41549e-18
    c345 (\9\:net3 0) capacitor c=7.96817e-18
    c346 (\2\:phi 0) capacitor c=6.81149e-18
    c347 (\5\:net1 0) capacitor c=5.62097e-19
    c348 (\6\:phi 0) capacitor c=1.67039e-17
    c349 (\8\:net2 0) capacitor c=5.7589e-17
    c350 (\11\:net1 0) capacitor c=2.45703e-19
    c351 (\5\:net3 0) capacitor c=3.10594e-19
    c352 (\9\:net2 0) capacitor c=5.96339e-17
    c353 (\12\:phi 0) capacitor c=1.40471e-17
    c354 (\11\:net3 0) capacitor c=1.67456e-18
    c355 (net1 0) capacitor c=6.70305e-21
    c356 (net3 0) capacitor c=5.32119e-20
    c357 (\4\:net1 0) capacitor c=3.64622e-19
    c358 (\4\:net2 0) capacitor c=7.93311e-19
    c359 (\4\:vdd! 0) capacitor c=2.89728e-19
    c360 (\10\:net1 0) capacitor c=1.44748e-18
    c361 (\13\:phi 0) capacitor c=2.70933e-18
    c362 (\2\:net1 0) capacitor c=1.24072e-17
    c363 (\2\:net2 0) capacitor c=5.34592e-19
    c364 (\2\:net3 0) capacitor c=6.75117e-18
    c365 (\2\:I13\|net2 0) capacitor c=5.70175e-18
    c366 (\5\:I13\|net2 0) capacitor c=4.61907e-18
    c367 (\2\:Y 0) capacitor c=1.51741e-17
    c368 (\5\:Y 0) capacitor c=2.82908e-18
    c369 (\10\:vdd! 0) capacitor c=5.57596e-19
    c370 (\16\:vdd! 0) capacitor c=5.57596e-19
    rh1 (\11\:net1 \5\:net1) resistor r=1.7877 c=0
    rh2 (\9\:net2 \8\:net2) resistor r=0.447 c=0
    rh3 (\12\:phi \6\:phi) resistor r=0.8246 c=0
    rh4 (\6\:phi \2\:phi) resistor r=0.3621 c=0
    rh5 (\11\:net3 \5\:net3) resistor r=1.7552 c=0
    ri1 (\1\:phi phi) resistor r=0.001833 c=0
    ri2 (phi \2\:phi) resistor r=1.4045 c=0
    ri3 (\1\:A A) resistor r=10.0424 c=0
    ri5 (\2\:net1 \4\:net1) resistor r=0.4727 c=0
    ri6 (\4\:net1 \5\:net1) resistor r=0.2394 c=0
    ri7 (\5\:net1 \7\:net1) resistor r=0.1987 c=0
    ri9 (net1 \2\:net1) resistor r=15 c=0
    ri10 (\6\:net1 \7\:net1) resistor r=15 c=0
    ri11 (\6\:phi \7\:phi) resistor r=1.45 c=0
    ri13 (\1\:B B) resistor r=10.0408 c=0
    ri15 (\2\:net2 \4\:net2) resistor r=0.4659 c=0
    ri16 (\4\:net2 \6\:net2) resistor r=0.4727 c=0
    ri18 (\6\:net2 \8\:net2) resistor r=1.528 c=0
    ri19 (net2 \2\:net2) resistor r=15 c=0
    ri20 (\5\:net2 \6\:net2) resistor r=15 c=0
    ri21 (\1\:phi_bar phi_bar) resistor r=10.0392 c=0
    ri22 (\9\:net1 \10\:net1) resistor r=0.01487 c=0
    ri23 (\10\:net1 \11\:net1) resistor r=1.9252 c=0
    ri25 (\2\:net3 \4\:net3) resistor r=0.4847 c=0
    ri26 (\4\:net3 \5\:net3) resistor r=0.2171 c=0
    ri27 (\5\:net3 \6\:net3) resistor r=0.152 c=0
    ri29 (net3 \2\:net3) resistor r=15 c=0
    ri30 (\7\:net3 \6\:net3) resistor r=15 c=0
    ri32 (\2\:I13\|net2 \5\:I13\|net2) resistor r=1.2027 c=0
    ri34 (I13\|net2 \2\:I13\|net2) resistor r=15 c=0
    ri35 (\4\:I13\|net2 \5\:I13\|net2) resistor r=15 c=0
    ri36 (\9\:net2 \10\:net2) resistor r=1.8734 c=0
    ri38 (\12\:phi \13\:phi) resistor r=1.405 c=0
    ri39 (\13\:phi \14\:phi) resistor r=10.0217 c=0
    ri41 (\9\:net3 \11\:net3) resistor r=1.5321 c=0
    ri43 (\2\:Y Y) resistor r=0.4727 c=0
    ri44 (Y \5\:Y) resistor r=0.4659 c=0
    ri46 (\1\:Y \2\:Y) resistor r=15 c=0
    ri47 (\4\:Y \5\:Y) resistor r=15 c=0
    ri49 (\2\:gnd! 0) resistor r=0.3147 c=0
    ri50 (\5\:gnd! 0) resistor r=0.6837 c=0
    ri51 (0 \6\:gnd!) resistor r=0.2485 c=0
    ri52 (0 \7\:gnd!) resistor r=0.9273 c=0
    ri53 (0 \4\:gnd!) resistor r=16.3638 c=0
    ri54 (0 \9\:gnd!) resistor r=0.3667 c=0
    ri56 (0 \12\:gnd!) resistor r=0.3147 c=0
    ri58 (0 \15\:gnd!) resistor r=0.3147 c=0
    ri60 (\1\:gnd! \2\:gnd!) resistor r=15 c=0
    ri61 (\4\:gnd! \5\:gnd!) resistor r=15 c=0
    ri62 (\4\:gnd! \6\:gnd!) resistor r=15 c=0
    ri63 (\4\:gnd! \7\:gnd!) resistor r=15 c=0
    ri64 (\8\:gnd! \9\:gnd!) resistor r=15 c=0
    ri65 (\11\:gnd! \12\:gnd!) resistor r=15 c=0
    ri66 (\14\:gnd! \15\:gnd!) resistor r=15 c=0
    ri67 (\2\:vdd! vdd!) resistor r=1.3162 c=0
    ri68 (\3\:vdd! vdd!) resistor r=0.7212 c=0
    ri69 (vdd! \4\:vdd!) resistor r=0.5896 c=0
    ri70 (vdd! \6\:vdd!) resistor r=0.5772 c=0
    ri72 (vdd! \8\:vdd!) resistor r=0.3038 c=0
    ri73 (vdd! \10\:vdd!) resistor r=0.5772 c=0
    ri76 (vdd! \14\:vdd!) resistor r=1.0037 c=0
    ri77 (vdd! \16\:vdd!) resistor r=0.5772 c=0
    ri79 (\1\:vdd! \2\:vdd!) resistor r=15 c=0
    ri80 (\1\:vdd! \3\:vdd!) resistor r=15 c=0
    ri81 (\5\:vdd! \6\:vdd!) resistor r=15 c=0
    ri82 (\1\:vdd! \8\:vdd!) resistor r=15 c=0
    ri83 (\9\:vdd! \10\:vdd!) resistor r=15 c=0
    ri84 (\12\:vdd! \4\:vdd!) resistor r=15 c=0
    ri85 (\1\:vdd! \14\:vdd!) resistor r=15 c=0
    ri86 (\15\:vdd! \16\:vdd!) resistor r=15 c=0
    rj1 (\3\:phi \4\:phi) resistor r=95.8206 c=0
    rj2 (\4\:phi \5\:phi) resistor r=59.3206 c=0
    rj3 (\1\:phi \4\:phi) resistor r=10 c=0
    rj4 (\2\:A \1\:A) resistor r=48.2228 c=0
    rj5 (\9\:phi \10\:phi) resistor r=95.8206 c=0
    rj6 (\10\:phi \11\:phi) resistor r=59.3206 c=0
    rj7 (\7\:phi \10\:phi) resistor r=10 c=0
    rj8 (\2\:B \1\:B) resistor r=48.2228 c=0
    rj9 (\2\:phi_bar \1\:phi_bar) resistor r=79.9673 c=0
    rj10 (\1\:phi_bar \3\:phi_bar) resistor r=47.7927 c=0
    rj11 (\12\:net1 \9\:net1) resistor r=37.7927 c=0
    rj12 (\12\:net2 \10\:net2) resistor r=38.7927 c=0
    rj13 (\15\:phi \14\:phi) resistor r=95.8206 c=0
    rj14 (\14\:phi \16\:phi) resistor r=59.3206 c=0
    rj15 (\12\:net3 \9\:net3) resistor r=58.2228 c=0
    I13\|PM0 (\4\:I13\|net2 \3\:phi_bar \12\:vdd! \1\:vdd!) gpdk090_pmos1v \
        w=4.8e-07 l=1e-07 as=1.344e-13 ad=7.68e-14 ps=1.52e-06 pd=8e-07 \
        m=(1)*(1)
    I13\|PM1 (\7\:net3 \12\:net1 \4\:I13\|net2 \1\:vdd!) gpdk090_pmos1v \
        w=4.8e-07 l=1e-07 as=7.68e-14 ad=7.68e-14 ps=8e-07 pd=8e-07 \
        m=(1)*(1)
    I13\|PM2 (I13\|net2 \12\:net2 \7\:net3 \1\:vdd!) gpdk090_pmos1v \
        w=4.8e-07 l=1e-07 as=7.68e-14 ad=1.344e-13 ps=8e-07 pd=1.52e-06 \
        m=(1)*(1)
    I12\|PM0 (\4\:Y \15\:phi \5\:vdd! \1\:vdd!) gpdk090_pmos1v w=2.4e-07 \
        l=1e-07 as=6.72e-14 ad=6.72e-14 ps=1.04e-06 pd=1.04e-06 m=(1)*(1)
    I11\|PM0 (net2 \9\:phi \9\:vdd! \1\:vdd!) gpdk090_pmos1v w=2.4e-07 \
        l=1e-07 as=6.72e-14 ad=6.72e-14 ps=1.04e-06 pd=1.04e-06 m=(1)*(1)
    I10\|PM0 (\6\:net1 \3\:phi \15\:vdd! \1\:vdd!) gpdk090_pmos1v \
        w=2.4e-07 l=1e-07 as=6.72e-14 ad=6.72e-14 ps=1.04e-06 pd=1.04e-06 \
        m=(1)*(1)
    I13\|NM0 (net3 \2\:phi_bar \8\:gnd! \4\:gnd!) gpdk090_nmos1v w=1.2e-07 \
        l=1e-07 as=6.96e-14 ad=6.96e-14 ps=1.16e-06 pd=1.16e-06 m=(1)*(1)
    I12\|NM1 (I12\|net2 \16\:phi \1\:gnd! \4\:gnd!) gpdk090_nmos1v \
        w=2.4e-07 l=1e-07 as=6.72e-14 ad=1.44e-14 ps=1.04e-06 pd=3.6e-07 \
        m=(1)*(1)
    I12\|NM0 (\1\:Y \12\:net3 I12\|net2 \4\:gnd!) gpdk090_nmos1v w=2.4e-07 \
        l=1e-07 as=1.44e-14 ad=6.72e-14 ps=3.6e-07 pd=1.04e-06 m=(1)*(1)
    I11\|NM1 (I11\|net2 \11\:phi \11\:gnd! \4\:gnd!) gpdk090_nmos1v \
        w=2.4e-07 l=1e-07 as=6.72e-14 ad=1.44e-14 ps=1.04e-06 pd=3.6e-07 \
        m=(1)*(1)
    I11\|NM0 (\5\:net2 \2\:B I11\|net2 \4\:gnd!) gpdk090_nmos1v w=2.4e-07 \
        l=1e-07 as=1.44e-14 ad=6.72e-14 ps=3.6e-07 pd=1.04e-06 m=(1)*(1)
    I10\|NM1 (I10\|net2 \5\:phi \14\:gnd! \4\:gnd!) gpdk090_nmos1v \
        w=2.4e-07 l=1e-07 as=6.72e-14 ad=1.44e-14 ps=1.04e-06 pd=3.6e-07 \
        m=(1)*(1)
    I10\|NM0 (net1 \2\:A I10\|net2 \4\:gnd!) gpdk090_nmos1v w=2.4e-07 \
        l=1e-07 as=1.44e-14 ad=6.72e-14 ps=3.6e-07 pd=1.04e-06 m=(1)*(1)
ends lab2_nora
// End of subcircuit definition.

// Library name: ece4740
// Cell name: lab2_nora_sim
// View name: schematic
I0 (A B Y net4 net5) lab2_nora
I1 (A B) lab2_signal_gen clk_period=1e-09 clk_period2=5e-10 clk_high=1.2 \
        clk_low=0 trise=2e-11 tfall=2e-11
C0 (Y 0) capacitor c=20f
V3 (net5 0) vsource type=pulse val0=1.2 val1=0 period=500p delay=0 \
        rise=20p fall=20p
V0 (net4 0) vsource type=pulse val0=0 val1=1.2 period=500p delay=0 \
        rise=20p fall=20p
V2 (vdd! 0) vsource dc=1.2 type=dc
simulatorOptions options psfversion="1.4.0" reltol=1e-3 vabstol=1e-6 \
    iabstol=1e-12 temp=25.0 tnom=27 scalem=1.0 scale=1.0 gmin=1e-12 \
    rforce=1 maxnotes=5 maxwarns=5 digits=5 cols=80 pivrel=1e-3 \
    sensfile="../psf/sens.output" checklimitdest=psf
tran tran stop=10n write="spectre.ic" writefinal="spectre.fc" \
    annotate=status maxiters=5
finalTimeOP info what=oppoint where=rawfile
modelParameter info what=models where=rawfile
element info what=inst where=rawfile
outputParameter info what=output where=rawfile
designParamVals info what=parameters where=rawfile
primitives info what=primitives where=rawfile
subckts info what=subckts where=rawfile
saveOptions options save=allpub
ahdl_include "/home/pis7/Cadence/ece4740/lab2_signal_gen/veriloga/veriloga.va"
